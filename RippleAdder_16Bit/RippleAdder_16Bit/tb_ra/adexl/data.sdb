ADE simulation setup
Run mode: Single Run, Sweeps and Corners
Tests:
  RippleAdder_16Bit:tb_ra:1: RippleAdder_16Bit/tb_ra/schematic, simulator spectre
