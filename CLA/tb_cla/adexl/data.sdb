ADE simulation setup
Run mode: Single Run, Sweeps and Corners
Tests:
  CLA:tb_cla:1: CLA/tb_cla/schematic, simulator spectre
Global variables:
  V0 = 1.2 (off)
  x_value = 1.2
Corners (nominal off):
  model folders: /CMC/kits/GPDK45/gpdk045_v_6_0/gpdk045/../models/spectre
  FF (off): temperature=-25; gpdk045.scs[ff]
  TT: temperature=-27; gpdk045.scs[tt]
  SS (off): temperature=-85; gpdk045.scs[ss]
