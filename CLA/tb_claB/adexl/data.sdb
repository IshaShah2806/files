ADE simulation setup
Run mode: Single Run, Sweeps and Corners
Tests:
  CLA:tb_claB:1: CLA/tb_claB/schematic, simulator spectre
Corners (nominal off):
  model folders: /CMC/kits/GPDK45/gpdk045_v_6_0/gpdk045/../models/spectre
  FF: temperature=25; gpdk045.scs[ff]
  TT: temperature=27; gpdk045.scs[tt]
  SS: temperature=85; gpdk045.scs[ss]
