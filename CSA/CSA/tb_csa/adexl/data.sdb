ADE simulation setup
Run mode: Single Run, Sweeps and Corners
Tests:
  CSA:tb_csa:1: CSA/tb_csa/schematic, simulator spectre
