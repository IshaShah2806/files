ADE simulation setup
Run mode: Single Run, Sweeps and Corners
Tests:
  FullAdder:fa_tb:1: FullAdder/fa_tb/schematic, simulator spectre
