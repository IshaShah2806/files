ADE simulation setup
Run mode: Single Run, Sweeps and Corners
Tests:
  FullAdder:fa_tb:1: FullAdder/fa_tb/config, simulator spectre
Corners (nominal off):
  model folders: /CMC/kits/GPDK45/gpdk045_v_6_0/gpdk045/../models/spectre
  FF (off): gpdk045.scs[ff]
  FS (off): gpdk045.scs[fs]
  SF (off): gpdk045.scs[sf]
  SS (off): gpdk045.scs[ss]
  TT: gpdk045.scs[tt]
  MC (off): gpdk045.scs[mc]
