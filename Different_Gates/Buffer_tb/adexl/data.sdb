ADE simulation setup
Run mode: Single Run, Sweeps and Corners
Tests:
  Different_Gates:Buffer_tb:1: Different_Gates/Buffer_tb/schematic, simulator spectre
